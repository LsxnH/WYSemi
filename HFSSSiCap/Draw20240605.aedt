# Ansys Electronics Desktop project, version 2018.0
materials:
  vacuum: permittivity=1
  silicon: permittivity=11.9

design HFSSDesign1 (HFSS, DrivenModal, model units mm)
geometry:
  Box1 [silicon] = box(corner=(1.4mm, 1.4mm, 0mm), size=(-3.2mm, -2.8mm, 0.8mm))
  Box2 = box(corner=(1.2mm, -1.2mm, 0mm), size=(-2.8mm, 0.2mm, 0.8mm))
  Box3 = box(corner=(1.2mm, -1.2mm, 0mm), size=(-2.8mm, 0.2mm, 0.8mm))
  Box3.move(0mm, 0.4mm, 0mm)
  Box1.subtract(Box2, Box3)
  Circle1 [vacuum] = circle(normal=Z, centre=(3.8mm, -0.6mm, 0mm), radius=1.2165525mm)
  plane Plane1 = base (5mm, 2.8mm, 0mm) normal (0mm, -0.6mm, 0mm)
  Cone1 [vacuum] = cone(axis=Z, base_centre=(-6mm, -3.5mm, 0mm), bottom_radius=1mm, top_radius=0mm, height=2.5mm)
  Cone2 [vacuum] = cone(axis=Z, base_centre=(-10.5mm, -2mm, 0mm), bottom_radius=1mm, top_radius=2.5495098mm, height=2.5mm)
  Cone3 [vacuum] = cone(axis=Z, base_centre=(0.5mm, -2.5mm, 0mm), bottom_radius=1.4142136mm, top_radius=0.70710678mm, height=3.5mm)
  Polyline1 [vacuum] = polyline(z=0mm, xy in mm: (4, 2.5) (6.5, 2) (3, 1) (1.5, 2) (4, 2.5), closed, covered, Spline from point 0 over 5)
  Polyline1.helix(XCenter=7.5mm YCenter=-1mm ZCenter=0mm XStartDir=-0.5mm YStartDir=0mm ZStartDir=0mm NumThread=1 RightHand=true RadiusIncrement=0mm Thread=1mm)
  Circle2 [vacuum] = circle(normal=Z, centre=(15mm, 5mm, 0mm), radius=2.236068mm)
  Circle2.helix(XCenter=-9mm YCenter=-3mm ZCenter=0mm XStartDir=-17mm YStartDir=-4mm ZStartDir=0mm NumThread=3 RightHand=true RadiusIncrement=-1mm Thread=4mm)
  Circle1.helix(XCenter=4.5mm YCenter=-1mm ZCenter=0mm XStartDir=-3.1mm YStartDir=-0.4mm ZStartDir=0.8mm NumThread=3 RightHand=true RadiusIncrement=-1mm Thread=4mm)
